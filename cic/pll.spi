* REY_PLL digital blocks for ciccreator/cicpy compile (cic/pll.json).
* The LVS reference is the xschem schematic of the same name; these
* subckts must stay equivalent to it. Instance letters are layout
* columns: XA.. is one column, XB.. the next, each starting with a tap.

* PFD: XA is the UP side (CK_REF flop, hold latch HU, RST = UP and DN),
* XB the DN side (CK_FB flop, hold latch HD, PWRUP_N)
.subckt REY_PLL_PFD VDD_1V8 VSS PWRUP_1V8 CK_REF CK_FB UP DN_N
XA0 VDD_1V8 VSS REYTR_TAPCELLB_CV
XA1 VDD_1V8 CK_REF RN_U UP UP_N VDD_1V8 VSS REYTR_DFRNQNX1_CV
XA2 HU CK_REF HAU VDD_1V8 VSS REYTR_ANX1_CV
XA3 HAU RST HU VDD_1V8 VSS REYTR_ORX1_CV
XA4 HU PWRUP_N RN_U VDD_1V8 VSS REYTR_NRX1_CV
XA5 UP DN RST VDD_1V8 VSS REYTR_ANX1_CV
XB0 VDD_1V8 VSS REYTR_TAPCELLB_CV
XB1 VDD_1V8 CK_FB RN_D DN DN_N VDD_1V8 VSS REYTR_DFRNQNX1_CV
XB2 HD CK_FB HAD VDD_1V8 VSS REYTR_ANX1_CV
XB3 HAD RST HD VDD_1V8 VSS REYTR_ORX1_CV
XB4 HD PWRUP_N RN_D VDD_1V8 VSS REYTR_NRX1_CV
XB5 PWRUP_1V8 PWRUP_N VDD_1V8 VSS REYTR_IVX1_CV
.ends
