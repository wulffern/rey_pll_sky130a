* REY_PLL standard cell blocks for cicpy compile (cic/pll.json).
* GENERATED by py/gen_pll.py, do not edit: the same definitions write the
* xschem schematics, so names and connections always agree. The
* instance letter is the layout column.

* REY_PLL_CTRL: power up, start-up kick and open loop modes
.subckt REY_PLL_CTRL VDD_1V8 VSS PWRUP_1V8 OLH OLL KICK VHI_N VLO
XA0 VDD_1V8 VSS REYTR_TAPCELLB_CV
XA1 PWRUP_1V8 PWRUP_N VDD_1V8 VSS REYTR_IVX1_CV
XA2 PWRUP_N KD0 VDD_1V8 VSS REYTR_IVX1_CV
XA3 KD0 KD1 VDD_1V8 VSS REYTR_IVX1_CV
XA4 KD1 KD2 VDD_1V8 VSS REYTR_IVX1_CV
XA5 KD2 KD3 VDD_1V8 VSS REYTR_IVX1_CV
XA6 KD3 KD4 VDD_1V8 VSS REYTR_IVX1_CV
XA7 PWRUP_1V8 PWRUP_NB VDD_1V8 VSS REYTR_IVX1_CV
XA8 PWRUP_NB KD4 KICK VDD_1V8 VSS REYTR_NRX1_CV
XA9 PWRUP_NB OLH VHI_N VDD_1V8 VSS REYTR_NRX1_CV
XA10 VHI_N OLL VLO VDD_1V8 VSS REYTR_ANX1_CV
.ends

* REY_PLL_PFD: tri-state phase frequency detector
.subckt REY_PLL_PFD VDD_1V8 VSS PWRUP_1V8 CK_REF CK_FB UP DN_N
XA0 VDD_1V8 VSS REYTR_TAPCELLB_CV
XA1 PWRUP_1V8 CK_REF RN_U UP UP_N VDD_1V8 VSS REYTR_DFRNQNX1_CV
XA2 UP DN RST VDD_1V8 VSS REYTR_ANX1_CV
XA3 HU PWRUP_N RN_U VDD_1V8 VSS REYTR_NRX1_CV
XA4 HAU RST HU VDD_1V8 VSS REYTR_ORX1_CV
XA5 HU CK_REF HAU VDD_1V8 VSS REYTR_ANX1_CV
XA6 PWRUP_1V8 PWRUP_N VDD_1V8 VSS REYTR_IVX1_CV
XA7 PWRUP_1V8 CK_FB RN_D DN DN_Q_N VDD_1V8 VSS REYTR_DFRNQNX1_CV
XA8 HD PWRUP_N RN_D VDD_1V8 VSS REYTR_NRX1_CV
XA9 HAD RST HD VDD_1V8 VSS REYTR_ORX1_CV
XA10 HD CK_FB HAD VDD_1V8 VSS REYTR_ANX1_CV
XA11 DN DN_N VDD_1V8 VSS REYTR_IVX1_CV
.ends

* REY_PLL_DIVN: 10 flop ripple divider, CK/64 to the PFD
.subckt REY_PLL_DIVN VDD_1V8 VSS CK CK_FB CKO0 CKO1 CKO2 CKO3 CKO4 CKO5 CKO6 CKO7
XA0 VDD_1V8 VSS REYTR_TAPCELLB_CV
XA1 QN0 CK VDD_1V8 Q0 QN0 VDD_1V8 VSS REYTR_DFRNQNX1_CV
XA2 QN1 Q0 VDD_1V8 Q1 QN1 VDD_1V8 VSS REYTR_DFRNQNX1_CV
XA3 Q1 Q1X VDD_1V8 VSS REYTR_IVX1_CV
XB0 VDD_1V8 VSS REYTR_TAPCELLB_CV
XB1 QN2 Q1 VDD_1V8 Q2 QN2 VDD_1V8 VSS REYTR_DFRNQNX1_CV
XB2 Q2 CKO0 VDD_1V8 VSS REYTR_BFX1_CV
XB3 QN3 Q2 VDD_1V8 Q3 QN3 VDD_1V8 VSS REYTR_DFRNQNX1_CV
XB4 Q3 CKO1 VDD_1V8 VSS REYTR_BFX1_CV
XC0 VDD_1V8 VSS REYTR_TAPCELLB_CV
XC1 QN4 Q3 VDD_1V8 Q4 QN4 VDD_1V8 VSS REYTR_DFRNQNX1_CV
XC2 Q4 CKO2 VDD_1V8 VSS REYTR_BFX1_CV
XC3 QN5 Q4 VDD_1V8 CK_FB QN5 VDD_1V8 VSS REYTR_DFRNQNX1_CV
XC4 CK_FB CKO3 VDD_1V8 VSS REYTR_BFX1_CV
XD0 VDD_1V8 VSS REYTR_TAPCELLB_CV
XD1 QN6 CK_FB VDD_1V8 Q6 QN6 VDD_1V8 VSS REYTR_DFRNQNX1_CV
XD2 Q6 CKO4 VDD_1V8 VSS REYTR_BFX1_CV
XD3 QN7 Q6 VDD_1V8 Q7 QN7 VDD_1V8 VSS REYTR_DFRNQNX1_CV
XD4 Q7 CKO5 VDD_1V8 VSS REYTR_BFX1_CV
XE0 VDD_1V8 VSS REYTR_TAPCELLB_CV
XE1 QN8 Q7 VDD_1V8 Q8 QN8 VDD_1V8 VSS REYTR_DFRNQNX1_CV
XE2 Q8 CKO6 VDD_1V8 VSS REYTR_BFX1_CV
XE3 QN9 Q8 VDD_1V8 Q9 QN9 VDD_1V8 VSS REYTR_DFRNQNX1_CV
XE4 Q9 CKO7 VDD_1V8 VSS REYTR_BFX1_CV
.ends

* REY_PLL_LPF: loop filter on VDD_1V8, eight REYPLL_RCU
.subckt REY_PLL_LPF VDD_1V8 VSS VCTRL VLPFZ
XA0 VCTRL R1 R1 R2 R2 R3 R3 R4 VSS VDD_1V8 VCTRL RCU
XA1 R4 R5 R5 R6 R6 R7 R7 R8 VSS VDD_1V8 VLPFZ RCU
XB0 R8 R9 R9 R10 R10 R11 R11 R12 VSS VDD_1V8 VLPFZ RCU
XB1 R12 R13 R13 R14 R14 R15 R15 R16 VSS VDD_1V8 VLPFZ RCU
XC0 R16 R17 R17 R18 R18 R19 R19 R20 VSS VDD_1V8 VLPFZ RCU
XC1 R20 R21 R21 R22 R22 R23 R23 R24 VSS VDD_1V8 VLPFZ RCU
XD0 R24 R25 R25 R26 R26 R27 R27 R28 VSS VDD_1V8 VLPFZ RCU
XD1 R28 R29 R29 R30 R30 R31 R31 VLPFZ VSS VDD_1V8 VLPFZ RCU
.ends
